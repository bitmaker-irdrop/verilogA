`include "constants.h"
`include "discipline.h"

module code_walker (vout);

    parameter real    step_time   = 20u;   // time held per code (s)
    parameter real    start_delay = 1u;    // initial delay before walking
    parameter real    vddc        = 1.2;   // logic high level
    parameter real    tt          = 1u;    // bit transition time
    parameter integer walk_mode   = 1 from [0:1];   // 0 = sawtooth, 1 = triangle
    parameter integer code_init   = 0 from [0:127]; // starting code

    output [6:0] vout;
    electrical [6:0] vout;

    integer out_code;     // code actually driven to vout
    integer dir;          // walk direction: +1 / -1 (triangle)

    localparam integer code_max = 127;   // 2^7 - 1

    analog begin
        @(initial_step) begin
            out_code = code_init;
            dir      = 1;
        end

        @(timer(start_delay, step_time)) begin
            if (walk_mode == 0) begin
                // sawtooth: 0 -> 127, reset to 0
                if (out_code >= code_max)
                    out_code = 0;
                else
                    out_code = out_code + 1;
            end else begin
                // triangle: 0 -> 127 -> 0
                if (out_code >= code_max)
                    dir = -1;
                else if (out_code <= 0)
                    dir = 1;
                out_code = out_code + dir;
            end
        end

        V(vout[0]) <+ transition(((out_code >> 0) & 1) * vddc, 0, tt);
        V(vout[1]) <+ transition(((out_code >> 1) & 1) * vddc, 0, tt);
        V(vout[2]) <+ transition(((out_code >> 2) & 1) * vddc, 0, tt);
        V(vout[3]) <+ transition(((out_code >> 3) & 1) * vddc, 0, tt);
        V(vout[4]) <+ transition(((out_code >> 4) & 1) * vddc, 0, tt);
        V(vout[5]) <+ transition(((out_code >> 5) & 1) * vddc, 0, tt);
        V(vout[6]) <+ transition(((out_code >> 6) & 1) * vddc, 0, tt);

        @(final_step)
            $strobe("CODE_WALKER done: last_code=%d", out_code);
    end

endmodule

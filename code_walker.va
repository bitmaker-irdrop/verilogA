`include "constants.h"
`include "discipline.h"

//============================================================================
//  code_walker
//
//  Walks a 6-bit digital code across the output bus: 0 -> 63 -> 0, cyclically.
//  Each code is held for step_time seconds (default 20 us).
//  Intended for sweeping the R-2R feedback DAC across all codes in TRAN:
//  at each code you can capture the settled Vout, check monotonicity,
//  and observe the transient on code transitions.
//
//  Fixed 6-bit bus: vout[5:0], levels 0 / vddc.
//
//  Walk modes (walk_mode):
//    0 = sawtooth:    0,1,2,...,63, 0,1,2,...   (reset to 0 after max)
//    1 = triangle:    0,1,...,63,62,...,1,0,1,...  (up then down)
//============================================================================

module code_walker (vout5, vout4, vout3, vout2, vout1, vout0);

    parameter real    step_time  = 20u;               // time per code (s) - 20 us
    parameter real    start_delay= 1u;                // delay before first step
    parameter real    vddc       = 1.2;               // logic high level (V)
    parameter real    tt         = 1u;                // bit transition time (s)
    parameter integer walk_mode  = 1    from [0:1];   // 0=sawtooth, 1=triangle
    parameter integer code_start = 0    from [0:63];  // initial code

    output vout5, vout4, vout3, vout2, vout1, vout0;
    electrical vout5, vout4, vout3, vout2, vout1, vout0;

    integer code;        // current code on the output
    integer dir;         // walk direction: +1 / -1 (triangle mode)

    localparam integer code_max = 63;   // 2^6 - 1

    analog begin
        @(initial_step) begin
            code = code_start;
            dir  = 1;
        end

        // every step_time seconds, starting at start_delay, advance the code
        @(timer(start_delay, step_time)) begin
            if (walk_mode == 0) begin
                // -------- sawtooth: 0..63, then reset to 0 --------
                if (code >= code_max)
                    code = 0;
                else
                    code = code + 1;
            end else begin
                // -------- triangle: 0..63..0.. --------
                // reverse direction at the endpoints
                if (code >= code_max)
                    dir = -1;
                else if (code <= 0)
                    dir = 1;
                code = code + dir;
            end
        end

        // ===== drive each bit explicitly (MSB = bit5, LSB = bit0) =====
        V(vout5) <+ transition(((code >> 5) & 1) * vddc, 0, tt);
        V(vout4) <+ transition(((code >> 4) & 1) * vddc, 0, tt);
        V(vout3) <+ transition(((code >> 3) & 1) * vddc, 0, tt);
        V(vout2) <+ transition(((code >> 2) & 1) * vddc, 0, tt);
        V(vout1) <+ transition(((code >> 1) & 1) * vddc, 0, tt);
        V(vout0) <+ transition(((code >> 0) & 1) * vddc, 0, tt);

        @(final_step)
            $strobe("CODE_WALKER done: last_code=%d", code);
    end

endmodule

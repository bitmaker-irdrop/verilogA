`include "constants.h"
`include "discipline.h"

//============================================================================
//  code_walker
//
//  Walks a 7-bit digital code on the output bus vout<6:0>: 0 -> 127 -> 0,
//  cyclically. Each code is held for step_time seconds (default 20 us).
//  Intended for sweeping the R-2R feedback DAC across all codes in TRAN:
//  at each code you can capture the settled Vout, check monotonicity,
//  and observe the transient on code transitions.
//
//  Bus vout[6:0], levels 0 / vddc. MSB = vout[6], LSB = vout[0].
//
//  Walk modes (walk_mode):
//    0 = sawtooth:    0,1,2,...,127, 0,1,2,...   (reset to 0 after max)
//    1 = triangle:    0,1,...,127,126,...,1,0,1,...  (up then down)
//============================================================================

module code_walker (vout);

    parameter real    step_time  = 20u;               // time per code (s) - 20 us
    parameter real    start_delay= 1u;                // delay before first step
    parameter real    vddc       = 1.2;               // logic high level (V)
    parameter real    tt         = 1u;                // bit transition time (s)
    parameter integer walk_mode  = 1    from [0:1];   // 0=sawtooth, 1=triangle
    parameter integer code_start = 0    from [0:127]; // initial code

    output [6:0] vout;
    electrical [6:0] vout;

    integer code;        // current code on the output
    integer dir;         // walk direction: +1 / -1 (triangle mode)

    localparam integer code_max = 127;   // 2^7 - 1

    analog begin
        @(initial_step) begin
            code = code_start;
            dir  = 1;
        end

        // every step_time seconds, starting at start_delay, advance the code
        @(timer(start_delay, step_time)) begin
            if (walk_mode == 0) begin
                // -------- sawtooth: 0..127, then reset to 0 --------
                if (code >= code_max)
                    code = 0;
                else
                    code = code + 1;
            end else begin
                // -------- triangle: 0..127..0.. --------
                // reverse direction at the endpoints
                if (code >= code_max)
                    dir = -1;
                else if (code <= 0)
                    dir = 1;
                code = code + dir;
            end
        end

        // ===== drive each bus bit explicitly (MSB = vout[6], LSB = vout[0]) =====
        V(vout[6]) <+ transition(((code >> 6) & 1) * vddc, 0, tt);
        V(vout[5]) <+ transition(((code >> 5) & 1) * vddc, 0, tt);
        V(vout[4]) <+ transition(((code >> 4) & 1) * vddc, 0, tt);
        V(vout[3]) <+ transition(((code >> 3) & 1) * vddc, 0, tt);
        V(vout[2]) <+ transition(((code >> 2) & 1) * vddc, 0, tt);
        V(vout[1]) <+ transition(((code >> 1) & 1) * vddc, 0, tt);
        V(vout[0]) <+ transition(((code >> 0) & 1) * vddc, 0, tt);

        @(final_step)
            $strobe("CODE_WALKER done: last_code=%d", code);
    end

endmodule
